* IVEP Mosyagin, var. 30: bridge rectifier + stabilizer
V1 in 0 SIN(0 {Vm} 60)
L1 in 0 {Ktr*Ktr*1u}
L2 sec b 1u
K1 L1 L2 0.99
VA1 sec a 0
D1 a f D_Mosyagin
D2 b f D_Mosyagin
D3 0 a D_Mosyagin
D4 0 b D_Mosyagin
C1 f 0 {Cf}
R1 f out {R1}
DZ1 0 out BZX84C12L_Mosyagin
Rn out 0 3k
.model D_Mosyagin D(IS=3p N=1.05 RS=10m TT=5n CJO=7p)
.model BZX84C12L_Mosyagin D(Is=.6n Rs=.5 Cjo=150p Nbv=5 Bv=12 Ibv=1m)
.param Vm=325.27 Ktr=22 Cf=320u R1=130
.options reltol=1e-5 abstol=1e-12 vntol=1e-7 method=gear
.control
save all @dz1[id]
tran 10u 0.27 0 10u uic
meas tran Uavg AVG v(out) from=0.2 to=0.2666667
meas tran Upp PP v(out) from=0.2 to=0.2666667
meas tran Umax MAX v(out) from=0.2 to=0.2666667
meas tran Umin MIN v(out) from=0.2 to=0.2666667
let Kp = 100*Upp/Uavg
meas tran Ufavg AVG v(f) from=0.2 to=0.2666667
meas tran Ufpp PP v(f) from=0.2 to=0.2666667
let Kpf = 100*Ufpp/Ufavg
meas tran Izavg AVG @dz1[id] from=0.2 to=0.2666667
meas tran Izmin MIN @dz1[id] from=0.2 to=0.2666667
meas tran Izmax MAX @dz1[id] from=0.2 to=0.2666667
print Kp Kpf
write br_stab_A.raw v(out) v(f) v(f) @dz1[id]
.endc
.end
