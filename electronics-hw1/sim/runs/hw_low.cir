* IVEP Mosyagin, var. 30: half-wave rectifier + stabilizer
V1 in 0 SIN(0 {Vm} 60)
L1 in 0 {Ktr*Ktr*1u}
L2 sec 0 1u
K1 L1 L2 0.99
VA1 sec a 0
D1 a f D_Mosyagin
C1 f 0 {Cf}
R1 f out {R1}
DZ1 0 out BZX84C12VL_Mosyagin
Rn out 0 3k
.model D_Mosyagin D(IS=3p N=1.05 RS=10m TT=5n CJO=7p)
.model BZX84C12VL_Mosyagin D(Is=926.42E-18 N=1.062
+ Rs=231.3m Ikf=4.908 Cjo=18.08p M=305.6m Vj=568m
+ Isr=4.364p Nr=4 Bv=12 Ibv=5m tt=185n Nbv=300m)
.param Vm=292.74 Ktr=20 Cf=680u R1=360
.options reltol=1e-5 abstol=1e-12 vntol=1e-7 method=gear
.control
save all @dz1[id]
tran 10u 0.27 0 10u uic
meas tran Uavg AVG v(out) from=0.2 to=0.2666667
meas tran Upp PP v(out) from=0.2 to=0.2666667
meas tran Umax MAX v(out) from=0.2 to=0.2666667
meas tran Umin MIN v(out) from=0.2 to=0.2666667
let Kp = 100*Upp/Uavg
meas tran Ufavg AVG v(f) from=0.2 to=0.2666667
meas tran Ufpp PP v(f) from=0.2 to=0.2666667
let Kpf = 100*Ufpp/Ufavg
meas tran Izavg AVG @dz1[id] from=0.2 to=0.2666667
meas tran Izmin MIN @dz1[id] from=0.2 to=0.2666667
meas tran Izmax MAX @dz1[id] from=0.2 to=0.2666667
print Kp Kpf
write hw_low.raw v(in) v(sec) v(out) i(VA1) v(f) @dz1[id]
.endc
.end
