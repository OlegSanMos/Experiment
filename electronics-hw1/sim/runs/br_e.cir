* IVEP Mosyagin, var. 30: bridge rectifier + stabilizer
V1 in 0 SIN(0 {Vm} 60)
L1 in 0 {Ktr*Ktr*1u}
L2 sec b 1u
K1 L1 L2 0.99
VA1 sec a 0
D1 a f D_Mosyagin
D2 b f D_Mosyagin
D3 0 a D_Mosyagin
D4 0 b D_Mosyagin
C1 f 0 {Cf}
R1 f out {R1}
DZ1 0 out BZX84C12VL_Mosyagin
Rn out 0 3k
.model D_Mosyagin D(IS=3p N=1.05 RS=10m TT=5n CJO=7p)
.model BZX84C12VL_Mosyagin D(Is=926.42E-18 N=1.062
+ Rs=231.3m Ikf=4.908 Cjo=18.08p M=305.6m Vj=568m
+ Isr=4.364p Nr=4 Bv=12 Ibv=5m tt=185n Nbv=300m)
.param Vm=357.8 Ktr=22 Cf=320u R1=130
.options reltol=1e-5 abstol=1e-12 vntol=1e-7 method=gear
.control
save all @dz1[id]
tran 10u 0.27 0 10u uic
meas tran Uavg AVG v(out) from=0.2 to=0.2666667
meas tran Upp PP v(out) from=0.2 to=0.2666667
meas tran Umax MAX v(out) from=0.2 to=0.2666667
meas tran Umin MIN v(out) from=0.2 to=0.2666667
let Kp = 100*Upp/Uavg
meas tran Ufavg AVG v(f) from=0.2 to=0.2666667
meas tran Ufpp PP v(f) from=0.2 to=0.2666667
let Kpf = 100*Ufpp/Ufavg
meas tran Izavg AVG @dz1[id] from=0.2 to=0.2666667
meas tran Izmin MIN @dz1[id] from=0.2 to=0.2666667
meas tran Izmax MAX @dz1[id] from=0.2 to=0.2666667
let ia = abs(i(VA1))
meas tran Ipusk MAX ia from=0 to=0.0333333
meas tran Ipk MAX ia from=0.2 to=0.2666667
meas tran Irms RMS i(VA1) from=0.2 to=0.2666667
meas tran Iavg AVG i(VA1) from=0.2 to=0.2666667
meas tran Iabs AVG ia from=0.2 to=0.2666667
let thr = 0.01*Ipk
meas tran ton WHEN ia=$&thr RISE=1 TD=0.2
meas tran toff WHEN ia=$&thr FALL=1 TD=$&ton
let tw = toff - ton
let thr2 = Umin - 0.001*Uavg
meas tran tset WHEN v(out)=$&thr2 CROSS=LAST
let ud1 = v(f) - v(a)
meas tran Urev1 MAX ud1 from=0.2 to=0.2666667
let ud3 = v(a)
meas tran Urev3 MAX ud3 from=0.2 to=0.2666667
print Kp Kpf tw
write br_e.raw v(in) v(sec) v(out) i(VA1) v(b) v(f) @dz1[id]
.endc
.end
